ADE simulation setup
Run mode: Single Run, Sweeps and Corners
Tests:
  MyBGR:Omar_test:1: MyBGR/Omar_test/schematic, simulator spectre
    Outputs: Vref
Corners:
  model folders: /home/cadence/tsmc65nm/models/spectre
  TT: temperature=125; crn65gplus_2d5_lk_v1d0.scs[tt_25, tt_bip, tt_lvt]
  FF: temperature=125; crn65gplus_2d5_lk_v1d0.scs[ff_25, ff_bip, ff_lvt]
  SS: temperature=125; crn65gplus_2d5_lk_v1d0.scs[ss_25, ss_bip, ss_lvt]
  SF: temperature=125; crn65gplus_2d5_lk_v1d0.scs[sf_25, sf_bip, sf_lvt]
  FS: temperature=125; crn65gplus_2d5_lk_v1d0.scs[fs_25, fs_bip, fs_lvt]
