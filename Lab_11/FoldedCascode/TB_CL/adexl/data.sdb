ADE simulation setup
Run mode: Single Run, Sweeps and Corners
Tests:
  FoldedCascode:TB_CL:1: FoldedCascode/TB_CL/schematic, simulator spectre
    Outputs: GBWCL; VINP; VINN; Settletime; VIDIFF
Global variables:
  VICM = 0.5
  VICMAC = 0
  VID = 0
  VIDAC = 1
Specs:
  FoldedCascode:TB_CL:1 / Settletime: < 100n
