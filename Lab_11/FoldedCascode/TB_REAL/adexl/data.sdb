ADE simulation setup
Run mode: Single Run, Sweeps and Corners
Tests:
  FoldedCascode:TB_REAL:1: FoldedCascode/TB_REAL/schematic, simulator spectre
    Outputs: AOL; <AOL
Global variables:
  VICM = 0.5
  VICMAC = 0
  VID = 0
  VIDAC = 1
