ADE simulation setup
Run mode: Single Run, Sweeps and Corners
Tests:
  FoldedCascode:TB:1: FoldedCascode/TB/schematic, simulator spectre
Global variables:
  VICM = 0.5
  VICMAC = 0
  VID = 0
  VIDAC = 1
