ADE simulation setup
Run mode: Single Run, Sweeps and Corners
Tests:
  LDO:Schematic:1: LDO/Schematic/schematic, simulator spectre
Global variables:
  Lf = 500n
  Lin = 2u
  Lp = 2u
  Lt = 3u
  VDD = 1.2
  Vref = 0.5885
  Wf = 10u
  Win = 5u
  Wp = 6u
  Wt = 10u
  V1 = 1.2
  V2 = 0
  V3 = 0
  V4 = 0
  V5 = 0
  V6 = 0
  V7 = 0
  W = 10u
  Lref = 3u
  Wref = 5u
  R = 1.1262M
  R2 = 550.186k
Corners:
  model folders: /home/cadence/tsmc65nm/tsmcN65/../models/spectre
  C1: VDD=1.1,1.2,1.3; crn65gplus_2d5_lk_v1d0.scs[ff ss tt]
