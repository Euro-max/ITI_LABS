ADE simulation setup
Run mode: Single Run, Sweeps and Corners
Tests:
  MIllerOTA:Mill_tb:1: MIllerOTA/Mill_tb/schematic, simulator spectre
Global variables:
  VICM = 0.6
  VICMAC = 1
  VID = 0
  VIDAC = 1
