ADE simulation setup
Run mode: Single Run, Sweeps and Corners
Tests:
  Lab_09:5T_OTA_TB:1: Lab_09/5T_OTA_TB/config, simulator spectre
Global variables:
  CF = 4p
  CIN = 4p, 12p
  CL = 5p
  Cout = 5p
  FIN = 1k
  GM = 157.1u
  Iref = 10u
  Rout = 405k
  VDD = 1.8
  VICM = 1.35
  VINAC = 1
  VP = 50m
