ADE simulation setup
Run mode: Single Run, Sweeps and Corners
Tests:
  LabNoise:RC:1: LabNoise/RC/schematic, simulator spectre
Global variables:
  CPAR = 1p
  RPAR = 1k
  TAU = RPAR*CPAR
  TSTOP = 100*TAU
  TSTEP = TAU/100
