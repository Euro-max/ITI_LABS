ADE simulation setup
Run mode: Single Run, Sweeps and Corners
Tests:
  Lab08:OTA_behav_tb:1: Lab08/OTA_behav_tb/config, simulator spectre
Global variables:
  CF = 4p
  CIN = 4p,12p
  CL = 5p
  FIN = 1.759M
  IB = 10u
  VDDAC = 1
  VICM = 1.35
  VINAC = 1
  VP = 50m
  Av = {Inclusion List}2{Inclusion List}{From/To}Decade:50:10:50000{From/To} (off)
  wu = 30.76M
  COUT = GM/wu (off)
  GM = 155.9u (off)
  ROUT = Av/GM (off)
